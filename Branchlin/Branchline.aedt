# Ansys Electronics Desktop project, version 2024.2
materials:
  copper: permeability=0.999991 conductivity=58000000

design Circuit1 (Circuit)
options: SParamCircuitDef IntegrationMethod=FFT
components:
  A1 = MS_TRL(W=1.00833mm P=14.2059mm)
  A2 = MS_TRL(W=1.00833mm P=14.2059mm)
  A3 = MS_TRL(W=3.83865mm P=13.4342mm)
  A4 = MS_TRL(W=3.83865mm P=13.4342mm)
  port Port1 rz=50ohm iz=0ohm EnableNoise=false noisetemp=16.85cel
  port Port2 rz=50ohm iz=0ohm EnableNoise=false noisetemp=16.85cel
  port Port3 rz=50ohm iz=0ohm EnableNoise=false noisetemp=16.85cel
  port Port4 rz=50ohm iz=0ohm EnableNoise=false noisetemp=16.85cel
nets:
  Port1: A3.1, A2.1
  Port2: A3.0, A1.1
  Port3: A4.0, A1.0
  Port4: A4.1, A2.0
setups:
  LinearFrequency: LinearFrequencyData(false, 0.1, false, "", false) SweepDefinition{Variable=Freq Data="LINC 1GHz 5GHz 401"}
reports:
  S Parameter Plot 1: dB(S(Port1,Port1)), dB(S(Port1,Port2)), dB(S(Port1,Port3)), dB(S(Port1,Port4)) vs Freq on LinearFrequency : LinearFrequency
