# Ansys Electronics Desktop project, version 2024.2
materials:
  copper: permeability=0.999991 conductivity=58000000

design Circuit1 (Circuit)
options: SParamCircuitDef IntegrationMethod=FFT
components:
  A1 = MS_TRL(W=1.59089mm P=13.9828mm)
  A2 = MS_TRL(W=1.59089mm P=13.9828mm)
  A3 = MS_TRL(W=1.59089mm P=13.9828mm)
  A4 = MS_TRL(W=1.59089mm P=13.9828mm)
  A5 = MS_TRL(W=1.59089mm P=13.9828mm)
  A6 = MS_TRL(W=1.59089mm P=13.9828mm)
  port Port1 rz=50ohm iz=0ohm EnableNoise=false noisetemp=16.85cel
  port Port2 rz=50ohm iz=0ohm EnableNoise=false noisetemp=16.85cel
  port Port3 rz=50ohm iz=0ohm EnableNoise=false noisetemp=16.85cel
  port Port4 rz=50ohm iz=0ohm EnableNoise=false noisetemp=16.85cel
nets:
  net_3: A5.1, A2.1
  net_6: A5.0, A4.1
  Port1: A6.1, A1.0
  Port2: A1.1, A2.0
  Port3: A3.0, A6.0
  Port4: A3.1, A4.0
setups:
  LinearFrequency: LinearFrequencyData(false, 0.1, false, "", false) SweepDefinition{Variable=Freq Data="LINC 1GHz 5GHz 401"}
reports:
  S Parameter Plot 1: dB(S(Port1,Port1)), dB(S(Port1,Port2)), dB(S(Port1,Port3)), dB(S(Port1,Port4)) vs Freq on LinearFrequency : LinearFrequency
