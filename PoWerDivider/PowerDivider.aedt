# Ansys Electronics Desktop project, version 2024.2
materials:
  copper: permeability=0.999991 conductivity=58000000

design Circuit1 (Circuit)
options: SParamCircuitDef IntegrationMethod=FFT
components:
  A1 = MS_TRL(W=1.86193mm P=18.6866mm)
  A2 = MS_TRL(W=3.8538mm P=18.3021mm)
  R5 = RES_(R=102.062)
  port Port1 rz=50ohm iz=0ohm EnableNoise=false noisetemp=16.85cel
  port Port2 rz=50ohm iz=0ohm EnableNoise=false noisetemp=16.85cel
  port Port3 rz=50ohm iz=0ohm EnableNoise=false noisetemp=16.85cel
nets:
  Port1: A2.0, A1.0
  Port2: A2.1, R5.1
  Port3: R5.0, A1.1
setups:
  LinearFrequency: LinearFrequencyData(false, 0.1, false, "", false) SweepDefinition{Variable=Freq Data="LINC 1GHz 5GHz 401"}
reports:
  S Parameter Plot 1: dB(S(Port1,Port1)), dB(S(Port2,Port1)), dB(S(Port3,Port1)), dB(S(Port1,Port2)), dB(S(Port2,Port2)), dB(S(Port3,Port2)), dB(S(Port1,Port3)), dB(S(Port2,Port3)), dB(S(Port3,Port3)) vs Freq on LinearFrequency : LinearFrequency
